;; =====================================================================
;; 05_from_schematic.ocn : netlist + simulate a SCHEMATIC from a library
;; (e.g. the rc_tb generated by examples/skill/create_testbench.il).
;; Needs cds.lib in the start directory that defines vagLib.
;; =====================================================================

vagLib  = "myLib"     ; <- your library
vagCell = "rc_tb"     ; <- testbench cell (created by create_testbench.il)

simulator('spectre)
design(vagLib vagCell "schematic")
resultsDir(sprintf(nil "./sim/%s" vagCell))

analysis('tran ?stop "40u")
analysis('ac ?start "1" ?stop "100M" ?dec "20")
desVar("rval" 1k)

createNetlist(?recreateAll t ?display nil)
run()

selectResult('ac)
printf("OCEAN_RESULT bw_hz=%g\n" bandwidth(v("/out") 3 "low"))
exit()
